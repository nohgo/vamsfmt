module loops(p);
  electrical [3:0] p;
  integer i;
  real total;
  analog initial total = 0;
  analog begin : evaluate
    real tmp;
    tmp = 0;
    for (i = 0; i < 4; i = i + 1) begin
      tmp = tmp + V(p[i]);
      I(p[i]) <+ ddt(V(p[i]));
    end
    while (tmp < 1) tmp = tmp + 1;
    repeat (2) tmp = tmp / 2;
    $strobe("total = %g", tmp);
  end
endmodule
