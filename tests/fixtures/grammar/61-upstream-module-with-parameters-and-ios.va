module mod #(
  parameter A = 5
)(
  output reg [A - 1 : 0] out
  // output reg [(A - 1): 0] out
);

endmodule
